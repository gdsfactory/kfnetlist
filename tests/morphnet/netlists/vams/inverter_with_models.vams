paramset pch mosfet;
endparamset
paramset nch mosfet;
endparamset
module cmos_inverter (in_, out, vdd, vss);
  inout in_, out, vdd, vss;
  pch #(.L(0.18u), .W(1u)) M1 (.d(out), .g(in_), .s(vdd), .b(vdd));
  nch #(.L(0.18u), .W(0.5u)) M2 (.d(out), .g(in_), .s(vss), .b(vss));
endmodule
